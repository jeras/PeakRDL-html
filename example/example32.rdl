////////////////////////////////////////////////////////////////////////////////
// example memory map for 32-bit system bus
// TODO: add license
////////////////////////////////////////////////////////////////////////////////

// various reusable definitions
//`include "fixed.rdl"
`include "float.rdl"

// example regfile-s
`include "example_fixed.rdl"
`include "example_simple.rdl"

// peripheral regfile-s
`include "gpio.rdl"
`include "uart.rdl"
`include "generic.rdl"

// tests
`include "test_field_properties.rdl"

addrmap example32 #(
    longint unsigned REGWIDTH = 32
){
    name = "32-bit bus example";
    desc = "Example for a 32-bit system bus, used for SystemRDL toolset testing.";

    // regwidth specifies the system bus width
    default regwidth = REGWIDTH;
    // accesswidth specifies the minimum width for read/write operations
    default accesswidth = REGWIDTH;

    reg array_unit #(
        longint unsigned WIDTH = 32
    ){
        name = "data array unit";
        desc = "Simple array of registers used for testing exporters (code generators).";
        field {
            sw = rw; hw = r;
        } data [WIDTH-1:0] = 0;
    };

    array_unit array_data[8];

    regfile {
        name = "test SystemRDL functionality";
        desc = "Tests for various SystemRDL features.";
        test_field_properties test_field_properties;
    } tests;

    uart uart0;
    uart uart1;
    uart uart2;
    uart uart3;

//    gpio #(.REGWIDTH (REGWIDTH), .WIDTH ( 8)) gpio8;
//    gpio #(.REGWIDTH (REGWIDTH), .WIDTH (16)) gpio16;
//    gpio #(.REGWIDTH (REGWIDTH), .WIDTH (24)) gpio24;
//    gpio #(.REGWIDTH (REGWIDTH), .WIDTH (32)) gpio32_1d [4];
//    gpio #(.REGWIDTH (REGWIDTH), .WIDTH (32)) gpio32_2d [3][2];

    configuration conf;
    control       ctrl;
    status        stat;
    vhdl_ufixed #(.MSB (24-1), .LSB (-8)) ufixed;

//    generic generic [2];
//
//    regfile {
//        // floating point registers and arrays
//        binary32 binary32_0d_a;
//        binary32 binary32_0d_b;
//        binary32 binary32_1d[4];
//        binary32 binary32_2d[3][2];
//        binary32 binary32_3d[2][3][5];
//
//        // unrolled generic[4]
//        configuration conf_0;
//        control       ctrl_0;
//        status        stat_0;
//        configuration conf_1;
//        control       ctrl_1;
//        status        stat_1;
//        configuration conf_2;
//        control       ctrl_2;
//        status        stat_2;
//        configuration conf_3;
//        control       ctrl_3;
//        status        stat_3;
//    } miscelaneous;
};
